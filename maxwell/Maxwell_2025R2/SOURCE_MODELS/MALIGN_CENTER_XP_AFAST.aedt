# Ansys Electronics Desktop project, version 2025.2
materials:
  vacuum: permittivity=1
  Core_Test_mu1000: permeability=1000
  copper: permeability=0.999991 conductivity=58000000
  steel_1008: permeability{HUnit=A_per_meter BUnit=tesla curve (0, 0) (159.2, 0.2402) (318.3, 0.8654) (477.5, 1.1106) (636.6, 1.2458) (795.8, 1.331) (1591.5, 1.5) (3183.1, 1.6) (4774.6, 1.683) (6366.2, 1.741) (7957.7, 1.78) (15915.5, 1.905) (31831, 2.025) (47746.5, 2.085) (63662, 2.13) (79577.5, 2.165) (159155, 2.28) (318310, 2.485) (397887, 2.5851)} conductivity=2000000

design Maxwell3DDesign1 (Maxwell 3D, AC Magnetic, model units mm)
geometry:
  U_Core [Core_Test_mu1000] = box(corner=(-15.65mm, -8mm, 20mm), size=(10.5mm, 16mm, 29mm))
  Box2 = box(corner=(5.15mm, -8mm, 20mm), size=(10.5mm, 16mm, 29mm))
  Box3 = box(corner=(-15.65mm, -8mm, 43mm), size=(31.3mm, 16mm, 6mm))
  U_Core.unite(Box2, Box3)
  Coil_Outer [copper] = box(corner=(-18.65mm, -11mm, 27mm), size=(16.5mm, 22mm, 12mm))
  Coil_Cut = box(corner=(-16mm, -8.35mm, 26mm), size=(11.2mm, 16.7mm, 14mm))
  Coil_Outer.subtract(Coil_Cut)
  Coil_Terminal_Sheet = rectangle(corner=(-18.65mm, 0mm, 27mm), z_size=12mm, x_size=2.65mm)
  Casting_Target [steel_1008] = imported_body(D:\Hongsk\aligner\MALIGN_Corner_Project_Package\geometry\Casting_Target.step)
  Casting_Target.move(-101.5mm, -81mm, 0mm)
  TargetSteel_PostWebX [steel_1008] = box(corner=(11.5mm, 16mm, -1318mm), size=(65mm, 5mm, 1200mm))
  TargetSteel_PostWebY = box(corner=(11.5mm, 16mm, -1318mm), size=(5mm, 65mm, 1200mm))
  TargetSteel_TopLongTop [steel_1008] = box(corner=(76.5mm, 26mm, -55mm), size=(900mm, 55mm, 5mm))
  TargetSteel_TopLongSide = box(corner=(76.5mm, 26mm, -55mm), size=(900mm, 5mm, 55mm))
  TargetSteel_TopCrossTop [steel_1008] = box(corner=(21.5mm, 81mm, -55mm), size=(55mm, 900mm, 5mm))
  TargetSteel_TopCrossSide = box(corner=(21.5mm, 81mm, -55mm), size=(5mm, 900mm, 55mm))
  TargetSteel_LongWallSkin [steel_1008] = box(corner=(76.5mm, 31mm, -1318mm), size=(900mm, 1.6mm, 1263mm))
  TargetSteel_CrossWallSkin [steel_1008] = box(corner=(26.5mm, 81mm, -1318mm), size=(1.6mm, 900mm, 1263mm))
  TargetSteel_LongCorrugation_000 [steel_1008] = box(corner=(76.5mm, 32.6mm, -1318mm), size=(65mm, 22mm, 1263mm))
  TargetSteel_LongCorrugation_001 [steel_1008] = box(corner=(226.5mm, 32.6mm, -1318mm), size=(65mm, 22mm, 1263mm))
  TargetSteel_LongCorrugation_002 [steel_1008] = box(corner=(376.5mm, 32.6mm, -1318mm), size=(65mm, 22mm, 1263mm))
  TargetSteel_LongCorrugation_003 [steel_1008] = box(corner=(526.5mm, 32.6mm, -1318mm), size=(65mm, 22mm, 1263mm))
  TargetSteel_LongCorrugation_004 [steel_1008] = box(corner=(676.5mm, 32.6mm, -1318mm), size=(65mm, 22mm, 1263mm))
  TargetSteel_LongCorrugation_005 [steel_1008] = box(corner=(826.5mm, 32.6mm, -1318mm), size=(65mm, 22mm, 1263mm))
  TargetSteel_CrossCorrugation_000 [steel_1008] = box(corner=(28.1mm, 81mm, -1318mm), size=(22mm, 65mm, 1263mm))
  TargetSteel_CrossCorrugation_001 [steel_1008] = box(corner=(28.1mm, 231mm, -1318mm), size=(22mm, 65mm, 1263mm))
  TargetSteel_CrossCorrugation_002 [steel_1008] = box(corner=(28.1mm, 381mm, -1318mm), size=(22mm, 65mm, 1263mm))
  TargetSteel_CrossCorrugation_003 [steel_1008] = box(corner=(28.1mm, 531mm, -1318mm), size=(22mm, 65mm, 1263mm))
  TargetSteel_CrossCorrugation_004 [steel_1008] = box(corner=(28.1mm, 681mm, -1318mm), size=(22mm, 65mm, 1263mm))
  TargetSteel_CrossCorrugation_005 [steel_1008] = box(corner=(28.1mm, 831mm, -1318mm), size=(22mm, 65mm, 1263mm))
  TargetSteel_RoofSheet [steel_1008] = box(corner=(76.5mm, 81mm, -76.5mm), size=(900mm, 900mm, 1.5mm))
  TargetSteel_PostWebX.unite(TargetSteel_PostWebY)
  TargetSteel_TopLongTop.unite(TargetSteel_TopLongSide)
  TargetSteel_TopCrossTop.unite(TargetSteel_TopCrossSide)
  Spreader_Holder_Xp [steel_1008] = box(corner=(33mm, -22mm, 67mm), size=(44mm, 44mm, 10mm))
  Spreader_Holder_Xm [steel_1008] = box(corner=(-77mm, -22mm, 67mm), size=(44mm, 44mm, 10mm))
  Spreader_Holder_Yp [steel_1008] = box(corner=(-22mm, 33mm, 67mm), size=(44mm, 44mm, 10mm))
  Spreader_Holder_Ym [steel_1008] = box(corner=(-22mm, -77mm, 67mm), size=(44mm, 44mm, 10mm))
  Spreader_Holder_Ref [steel_1008] = box(corner=(44mm, 44mm, 67mm), size=(44mm, 44mm, 10mm))
  Spreader_EndFrame_West [steel_1008] = box(corner=(-135mm, -135mm, 107mm), size=(24mm, 270mm, 28mm))
  Spreader_EndFrame_East [steel_1008] = box(corner=(111mm, -135mm, 107mm), size=(24mm, 270mm, 28mm))
  Spreader_EndFrame_South [steel_1008] = box(corner=(-111mm, -135mm, 107mm), size=(222mm, 24mm, 28mm))
  Spreader_EndFrame_North [steel_1008] = box(corner=(-111mm, 111mm, 107mm), size=(222mm, 24mm, 28mm))
  Spreader_EndBeam [steel_1008] = box(corner=(-180mm, -21mm, 147mm), size=(360mm, 42mm, 42mm))
  Spreader_Twistlock_Retracted [steel_1008] = box(corner=(-12mm, -12mm, 83mm), size=(24mm, 24mm, 22mm))
  [U_Core, Coil_Outer, Coil_Terminal_Sheet].move(55mm, 0mm, 0mm)
  U_Core1 [Core_Test_mu1000] = box(corner=(-15.65mm, -8mm, 20mm), size=(10.5mm, 16mm, 29mm))
  Box4 = box(corner=(5.15mm, -8mm, 20mm), size=(10.5mm, 16mm, 29mm))
  Box5 = box(corner=(-15.65mm, -8mm, 43mm), size=(31.3mm, 16mm, 6mm))
  U_Core1.unite(Box4, Box5)
  U_Core1.move(55mm, 0mm, 0mm)
  U_Core1.move(-110mm, 0mm, 0mm)
  U_Core2 [Core_Test_mu1000] = box(corner=(-15.65mm, -8mm, 20mm), size=(10.5mm, 16mm, 29mm))
  Box6 = box(corner=(5.15mm, -8mm, 20mm), size=(10.5mm, 16mm, 29mm))
  Box7 = box(corner=(-15.65mm, -8mm, 43mm), size=(31.3mm, 16mm, 6mm))
  U_Core2.unite(Box6, Box7)
  U_Core2.move(55mm, 0mm, 0mm)
  U_Core2.move(-55mm, 55mm, 0mm)
  U_Core3 [Core_Test_mu1000] = box(corner=(-15.65mm, -8mm, 20mm), size=(10.5mm, 16mm, 29mm))
  Box8 = box(corner=(5.15mm, -8mm, 20mm), size=(10.5mm, 16mm, 29mm))
  Box9 = box(corner=(-15.65mm, -8mm, 43mm), size=(31.3mm, 16mm, 6mm))
  U_Core3.unite(Box8, Box9)
  U_Core3.move(55mm, 0mm, 0mm)
  U_Core3.move(-55mm, -55mm, 0mm)
  U_Core4 [Core_Test_mu1000] = box(corner=(-15.65mm, -8mm, 20mm), size=(10.5mm, 16mm, 29mm))
  Box10 = box(corner=(5.15mm, -8mm, 20mm), size=(10.5mm, 16mm, 29mm))
  Box11 = box(corner=(-15.65mm, -8mm, 43mm), size=(31.3mm, 16mm, 6mm))
  U_Core4.unite(Box10, Box11)
  U_Core4.move(55mm, 0mm, 0mm)
  U_Core4.move(11mm, 66mm, 0mm)
  Region [vacuum] = region(absolute_offset=100mm on all sides)
  U_Core1.move(110mm, 0mm, 0mm)
  [U_Core, Coil_Outer, Coil_Terminal_Sheet].move(-110mm, 0mm, 0mm)
  U_Core2.move(-55mm, -55mm, 0mm)
  [U_Core, Coil_Outer, Coil_Terminal_Sheet].move(55mm, 55mm, 0mm)
  U_Core3.move(0mm, 110mm, 0mm)
  [U_Core, Coil_Outer, Coil_Terminal_Sheet].move(0mm, -110mm, 0mm)
  U_Core4.move(-66mm, -121mm, 0mm)
  [U_Core, Coil_Outer, Coil_Terminal_Sheet].move(66mm, 121mm, 0mm)
  U_Core1.move(11mm, 66mm, 0mm)
  [U_Core, Coil_Outer, Coil_Terminal_Sheet].move(-11mm, -66mm, 0mm)
boundaries and excitations:
  CoilTerminal1: Coil Terminal Objects=Coil_Terminal_Sheet Conductor_number=100 Winding=Winding_1 Point_out_of_terminal=false
  Winding_1: Winding Group Type=Current IsSolid=false Current=0.6A ParallelBranchesNum=1 Phase=0deg
  eddy effects on: Casting_Target, Spreader_Holder_Xp, Spreader_Holder_Xm, Spreader_Holder_Yp, Spreader_Holder_Ym, Spreader_Holder_Ref, Spreader_EndFrame_West, Spreader_EndFrame_East, Spreader_EndFrame_South, Spreader_EndFrame_North, Spreader_EndBeam, Spreader_Twistlock_Retracted, TargetSteel_CrossCorrugation_002, TargetSteel_CrossCorrugation_005, TargetSteel_CrossCorrugation_000, TargetSteel_RoofSheet, TargetSteel_LongWallSkin, TargetSteel_CrossCorrugation_004, TargetSteel_PostWebX, TargetSteel_CrossWallSkin, TargetSteel_CrossCorrugation_003, TargetSteel_TopLongTop, TargetSteel_LongCorrugation_004, TargetSteel_LongCorrugation_005, TargetSteel_CrossCorrugation_001, TargetSteel_LongCorrugation_000, TargetSteel_LongCorrugation_001, TargetSteel_LongCorrugation_002, TargetSteel_TopCrossTop, TargetSteel_LongCorrugation_003
parameters:
  Matrix1: Matrix Winding_1:
  Matrix_AC: Matrix Winding_1:
mesh:
  initial mesh: GlobalCurvilinear{Apply}
setups:
  Setup1: AC Magnetic MaximumPasses=22 MinimumPasses=8 MinimumConvergedPasses=2 PercentRefinement=12 PercentError=0.2 NonLinearResidual=0.0001 Frequency=3000Hz LossAdaptiveCtrl=0.5
